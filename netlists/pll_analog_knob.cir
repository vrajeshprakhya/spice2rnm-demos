* KNOB-NOISE VARIANT of pll_analog.cir, for demo 4c.
*
* Same circuit, two changes, and nothing else:
*   1. the loop filter's three resistors each carry thermal noise
*      (see the lpfilt subcircuit), so the VCO's control voltage, its
*      knob, shakes from inside the loop;
*   2. the supply is QUIET (pll_analog.cir puts 20 mV rms on it), so any
*      shake seen in this run comes from the knob alone.
* The noise is 1000x the resistors' real thermal noise, on purpose: a
* stress case so the effect is visible. The numbers are in lpfilt.
*
* PLL analog partition, driven from RTL through the co-simulation bridge.
*
* DERIVED from work/pll_analog.cir: identical cells and subcircuits, with
* the top level replaced so the charge pump's gate drives are EXTERNAL
* -- their values come from the digital simulator rather than from this
* deck. The detector and the divider are RTL and do not appear here at all,
* which is the whole point.
*
* Regenerate by taking work/pll_analog.cir up to its top-level section and
* appending the block at the end of this file.
*
* Only the blocks that come from schematic: the ring VCO, the charge-pump
* switches, and the passive loop filter. The phase-frequency detector and
* the divide-by-40 live in RTL and are NOT here -- which is the whole point
* of this deck. There are therefore no XSPICE code models and no
* adc_bridge/dac_bridge anywhere: the analog/digital boundary is a port,
* not a device.
*
* Consequences, stated so they are not mistaken for oversights:
*   - the VCO's output is an ANALOG node. There is no digital companion
*     output, because the thing that squares it up is the RTL's own input.
*   - the charge pump's UP/DOWN controls arrive as plain gate voltages on
*     nodes `pupb` (active low, PMOS gate) and `pdn` (active high, NMOS
*     gate). In the RTL flow those are driven by the PFD.
*   - `cont` is driven by the filter, which is driven by the pump. The loop
*     is NOT closed in SPICE; closing it is the RTL testbench's job.

.param vcc=3.3

*==================== transistor models ====================
.model N1 NMOS
*+version = 3.2.4
+version = 3.3.0
+Level=        8
+Tnom=27.0
+Nch= 2.498E+17  Tox=9E-09 Xj=1.00000E-07
+Lint=9.36e-8 Wint=1.47e-7
+Vth0= .6322    K1= .756  K2= -3.83e-2  K3= -2.612
+Dvt0= 2.812  Dvt1= 0.462  Dvt2=-9.17e-2
+Nlx= 3.52291E-08  W0= 1.163e-6
+K3b= 2.233
+Vsat= 86301.58  Ua= 6.47e-9  Ub= 4.23e-18  Uc=-4.706281E-11
+Rdsw= 650  U0= 388.3203 wr=1
+A0= .3496967 Ags=.1    B0=0.546    B1= 1
+Keta=-3.605872E-02  A1= 2.778747E-02  A2= .9
+Voff=-6.735529E-02  NFactor= 1.139926  Cit= 1.622527E-04
+Eta0= 1.0281729E-02  Etab=-5.042203E-03
+Dsub= .31871233 Pclm= 1.114846
+Pdiblc1= 2.45357E-03  Pdiblc2= 6.406289E-03
+Drout= .31871233  Pscbe1= 5000000  Pscbe2= 5E-09
+Pvag= 0 delta=0.01

.model P1 PMOS
+version = 3.3.0
+Level=        8
+Tnom=27.0
+Nch= 3.533024E+17  Tox=9E-09 Xj=1.00000E-07
+Lint=6.23e-8 Wint=1.22e-7
+Vth0=-.6732829 K1= .8362093  K2=-8.606622E-02  K3= 1.82
+Dvt0= 1.903801  Dvt1= .5333922  Dvt2=-.1862677
+Nlx= 1.28e-8  W0= 2.1e-6
+K3b= -0.24
+Vsat= 103503.2  Ua= 1.39995E-09  Ub= 1.e-19  Uc=-2.73e-11
+Rdsw= 460  U0= 138.7609
+A0= .4716551 Ags=0.12
+Keta=-1.871516E-03  A1= .3417965  A2= 0.83
+Voff=-.074182  NFactor= 1.54389  Cit=-1.015667E-03
+Eta0= 6.024776E-02  Etab=-4.64593E-03
+Dsub= .23222404 Pclm= .989
+Pdiblc1= 2.07418E-02  Pdiblc2= 1.33813E-3
+Drout= .3222404  Pscbe1= 118000  Pscbe2= 1E-09
+Pvag= 0

*==================== cells ====================
.subckt gaincell dd ss sub well co in- in+ out- out+
mn1  out- in+   ss  sub  n1  w=2u  l=0.35u  AS=3p AD=3p PS=4u PD=4u
mn2  out- out+  ss  sub  n1  w=2u  l=0.35u  AS=3p AD=3p PS=4u PD=4u
mn3  out+ out-  ss  sub  n1  w=2u  l=0.35u  AS=3p AD=3p PS=4u PD=4u
mn4  out+ in-   ss  sub  n1  w=2u  l=0.35u  AS=3p AD=3p PS=4u PD=4u
mp1  out- co    dd  well  p1  w=4u l=0.35u  AS=7p AD=7p PS=6u PD=6u
mp2  out+ co    dd  well  p1  w=4u l=0.35u  AS=7p AD=7p PS=6u PD=6u
.ends gaincell

.subckt inv1 dd ss sub well in out
mn1  out in  ss  sub  n1  w=2u  l=0.35u  AS=3p AD=3p PS=4u PD=4u
mp1  out in  dd  well  p1  w=4u l=0.35u  AS=7p AD=7p PS=6u PD=6u
.ends inv1

.subckt inv2 dd ss sub well in out
mn1  out in  ss  sub  n1  w=6u  l=0.35u  AS=12p AD=12p PS=16u PD=16u
mp1  out in  dd  well  p1  w=12u l=0.35u  AS=24p AD=24p PS=28u PD=28u
.ends inv2

*==================== ring VCO ====================
* Analog output only. Whatever squares this into a clock is downstream.
.subckt ro_vco aout cont dd
vin  inm1 outp7 dc 0
vin2 inp1 outm7 dc 0
vss  ss   0 dc 0
ve   sub  0 dc 0
vpe  well 0 dc 3.3
xinv1 dd ss sub well cont inm1  inp1  outm1 outp1 gaincell
xinv2 dd ss sub well cont outp1 outm1 outm2 outp2 gaincell
xinv3 dd ss sub well cont outp2 outm2 outm3 outp3 gaincell
xinv4 dd ss sub well cont outp3 outm3 outm4 outp4 gaincell
xinv5 dd ss sub well cont outp4 outm4 outm5 outp5 gaincell
xinv6 dd ss sub well cont outp5 outm5 outm6 outp6 gaincell
xinv7 dd ss sub well cont outp6 outm6 outm7 outp7 gaincell
xinv11 dd 0 sub well outm1 outm2 inv1
xinv12 dd 0 sub well outm2 aout inv2
cout  aout 0 0.2pF
.ends ro_vco

*==================== charge pump ====================
* UP is active low on the PMOS gate, DOWN active high on the NMOS gate --
* gate voltages, driven by the RTL detector. No bridge.
.subckt cpump pupb pdn dra dd
vss ss 0 dc 0
mnd dra pdn  ss ss n1 w=12u l=0.35u AS=24p AD=24p PS=28u PD=28u
mpd dra pupb dd dd p1 w=24u l=0.35u AS=48p AD=48p PS=52u PD=52u
.ends cpump

*==================== loop filter ====================
* Third-order passive. Driven by current from the pump.
.subckt lpfilt dra vout
* Each resistor carries its own thermal noise, written the way a resistor's
* noise is drawn on paper: a small random voltage in series with it. Each
* sits on a node of its own (n1, n2, n3) that nothing else touches.
*
* Amplitude: a resistor R makes white noise of 4kTR V^2/Hz. Held as a new
* random step every NT = 100 ps, that needs sqrt(2kTR/NT) rms (T = 300 K):
*   R1 300 ohm   157.6 uV     R2 200 ohm   128.7 uV     R3 50 ohm   64.4 uV
* THE CARDS BELOW ARE 1000x THOSE. At the real size the knob (vout) moves
* about 2.9 uV rms, sqrt(kT/C3), which no run here could see. 1000x puts it
* near 2.9 mV rms: a stress case, chosen so the effect is visible, not a
* claim about this circuit.
R1 dra  n1   300
Vn1 n1  int1 dc 0 trnoise(0.1576 1e-10 0 0)
R2 int1 n2   200
Vn2 n2  c1   dc 0 trnoise(0.1287 1e-10 0 0)
C1 c1   0    10n
C2 int1 0    5n
R3 int1 n3   50
Vn3 n3  vout dc 0 trnoise(0.06436 1e-10 0 0)
C3 vout 0    0.5n
.ends lpfilt

*==================== top level, driven from RTL ====================
* The pump's gate drives are EXTERNAL: their values come from the digital
* simulator through the bridge, not from this deck. That is the whole
* point -- the detector and the divider are RTL and never appear here.
vdd dd 0 dc {vcc}
Vpupb pupb 0 dc 0 external
Vpdn  pdn  0 dc 0 external

xcp  pupb pdn dra dd cpump
xlf  dra vout lpfilt
xvco aout vout dd ro_vco

* Start at the control voltage THIS CIRCUIT locks to, so the run checks the
* loop HOLDS lock rather than paying for a full acquisition -- at 50 ps
* steps an acquisition is hours of transistor-level SPICE, and holding lock
* is the cheaper question that still exercises every path around the loop.
*
* 1.8495 V is measured from the transistors alone: the co-simulation run out
* to 20 us at the 5 ps ceiling, where it reaches 400.00 MHz and vout settles
* into 1.8494..1.8497 V -- a 0.3 mV band.
*
* What this .ic buys is the FREQUENCY: the 3 us default run holds 400.00 MHz
* from the start rather than acquiring toward it. It does NOT make that run
* settled, and starting it at the right voltage does not damp it. vout still
* rings about 6 mV over 3 us -- up to 1.8531 V near 0.9 us, down to 1.8472 V
* near 2.0 us, climbing again at the end -- because that ring is the loop
* filter's own dynamics, and R2*C1 = 2 us sets it. An .ic on vout and dra
* pins two nodes at t=0; it cannot pin the filter's remaining state or the
* phase the divider happens to start in, which is what the loop rings out.
* Settling needs run length, not a better starting point.
*
* The previous value, 1.8473 V, was measured the same way and from the same
* circuit, but at the 20 ps ceiling, which simulates this ring slow enough to
* move the lock point: it reported 1.8467..1.8484 V. That is 2.1 mV from
* where this circuit sits, and larger than the 1.85 mV bar the models are
* judged against -- so the reference's own timestep was setting the starting
* condition for the experiment that judges them. A value from a COARSE run
* fails the same way as one from a SHORT run, and is harder to notice,
* because nothing about it looks short.
*
* Before that, 1.8086 V was the lock point of a COMPOSED RNM rather than of
* this circuit. That made the reference run's starting condition a function
* of the model it is the reference for, and the 39 mV between them was then
* read as the model's error.
*
* Whatever stands here has to come from the transistors, simulated finely
* enough that the number is the circuit's and not the timestep's.
.ic v(vout)=1.8495 v(dra)=1.8495
.end
